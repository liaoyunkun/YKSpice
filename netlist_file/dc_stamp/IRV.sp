test for stamp R, Vsrc, Isrc
*V(2)=4
R1 1 2 5
R2 2 0 10
Vsrc 1 0 1
Isrc 0 2 1
.OP
.END
