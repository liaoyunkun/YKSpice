test3- from lecture06 P13,14
*test for stamping for E and G
*v(1)=16.0555
*v(2)=17.5375
*v(3)=18.5375
*v(4)=-19.2665
*I(VS)=-7.56081
*I(E7)=7.56081
R1 1 0 5
G2 1 0 1 2 2
R3 1 2 6
R4 2 0 8
Is 0 2 10
Vs 3 2 1
R8 3 4 5
E7 4 0 1 2 13
.OP
.END
